simulator lang=spectre insensitive=yes

include "$TSMC_DIR/oa/models/spectre/crn65lp_2d5_lk_v1d7.scs" section=tt_bip_npn
include "$TSMC_DIR/oa/models/spectre/crn65lp_2d5_lk_v1d7.scs" section=tt_rfres_sa
include "$TSMC_DIR/oa/models/spectre/crn65lp_2d5_lk_v1d7.scs" section=tt_rfmvar
include "$TSMC_DIR/oa/models/spectre/crn65lp_2d5_lk_v1d7.scs" section=tt_dio_esd
include "$TSMC_DIR/oa/models/spectre/crn65lp_2d5_lk_v1d7.scs" section=tt_rtmom
include "$TSMC_DIR/oa/models/spectre/crn65lp_2d5_lk_v1d7.scs" section=tt_rfmvar_25
include "$TSMC_DIR/oa/models/spectre/crn65lp_2d5_lk_v1d7.scs" section=tt_disres
include "$TSMC_DIR/oa/models/spectre/crn65lp_2d5_lk_v1d7.scs" section=tt_dio_na
include "$TSMC_DIR/oa/models/spectre/crn65lp_2d5_lk_v1d7.scs" section=tt
include "$TSMC_DIR/oa/models/spectre/crn65lp_2d5_lk_v1d7.scs" section=tt_lowcpad
include "$TSMC_DIR/oa/models/spectre/crn65lp_2d5_lk_v1d7.scs" section=tt_mim
include "$TSMC_DIR/oa/models/spectre/crn65lp_2d5_lk_v1d7.scs" section=tt_rfrtmom
include "$TSMC_DIR/oa/models/spectre/crn65lp_2d5_lk_v1d7.scs" section=tt_dio_na25od33
include "$TSMC_DIR/oa/models/spectre/crn65lp_2d5_lk_v1d7.scs" section=tt_dio_hvt
include "$TSMC_DIR/oa/models/spectre/crn65lp_2d5_lk_v1d7.scs" section=tt_rfres_rpo
include "$TSMC_DIR/oa/models/spectre/crn65lp_2d5_lk_v1d7.scs" section=tt_na25od33
include "$TSMC_DIR/oa/models/spectre/crn65lp_2d5_lk_v1d7.scs" section=tt_rfmim
include "$TSMC_DIR/oa/models/spectre/crn65lp_2d5_lk_v1d7.scs" section=tt_res
include "$TSMC_DIR/oa/models/spectre/crn65lp_2d5_lk_v1d7.scs" section=tt_dio_lvt
include "$TSMC_DIR/oa/models/spectre/crn65lp_2d5_lk_v1d7.scs" section=tt_rfmos_hvt
include "$TSMC_DIR/oa/models/spectre/crn65lp_2d5_lk_v1d7.scs" section=tt_rfmos_mlvt
include "$TSMC_DIR/oa/models/spectre/crn65lp_2d5_lk_v1d7.scs" section=tt_bip
include "$TSMC_DIR/oa/models/spectre/crn65lp_2d5_lk_v1d7.scs" section=tt_mos_cap
include "$TSMC_DIR/oa/models/spectre/crn65lp_2d5_lk_v1d7.scs" section=tt_18
include "$TSMC_DIR/oa/models/spectre/crn65lp_2d5_lk_v1d7.scs" section=tt_dio
include "$TSMC_DIR/oa/models/spectre/crn65lp_2d5_lk_v1d7.scs" section=tt_na
include "$TSMC_DIR/oa/models/spectre/crn65lp_2d5_lk_v1d7.scs" section=tt_hvt
include "$TSMC_DIR/oa/models/spectre/crn65lp_2d5_lk_v1d7.scs" section=tt_rfind
include "$TSMC_DIR/oa/models/spectre/crn65lp_2d5_lk_v1d7.scs" section=tt_dio_hia_rf
include "$TSMC_DIR/oa/models/spectre/crn65lp_2d5_lk_v1d7.scs" section=tt_rfmos_33
include "$TSMC_DIR/oa/models/spectre/crn65lp_2d5_lk_v1d7.scs" section=tt_lvt
include "$TSMC_DIR/oa/models/spectre/crn65lp_2d5_lk_v1d7.scs" section=tt_na25
include "$TSMC_DIR/oa/models/spectre/crn65lp_2d5_lk_v1d7.scs" section=tt_dio_dnw
include "$TSMC_DIR/oa/models/spectre/crn65lp_2d5_lk_v1d7.scs" section=tt_rfmos_25
include "$TSMC_DIR/oa/models/spectre/crn65lp_2d5_lk_v1d7.scs" section=tt_mlvt
include "$TSMC_DIR/oa/models/spectre/crn65lp_2d5_lk_v1d7.scs" section=tt_rfjvar
include "$TSMC_DIR/oa/models/spectre/crn65lp_2d5_lk_v1d7.scs" section=tt_rfmvar_hvt
include "$TSMC_DIR/oa/models/spectre/crn65lp_2d5_lk_v1d7.scs" section=tt_rfmos
include "$TSMC_DIR/oa/models/spectre/crn65lp_2d5_lk_v1d7.scs" section=tt_dio_na25
include "$TSMC_DIR/oa/models/spectre/crn65lp_2d5_lk_v1d7.scs" section=tt_rfmos_18
include "$TSMC_DIR/oa/models/spectre/crn65lp_2d5_lk_v1d7.scs" section=tt_mos_cap_25
include "$TSMC_DIR/oa/models/spectre/crn65lp_2d5_lk_v1d7.scs" section=tt_dio_33
include "$TSMC_DIR/oa/models/spectre/crn65lp_2d5_lk_v1d7.scs" section=tt_25
include "$TSMC_DIR/oa/models/spectre/crn65lp_2d5_lk_v1d7.scs" section=tt_33
include "$TSMC_DIR/oa/models/spectre/crn65lp_2d5_lk_v1d7.scs" section=tt_dio_mlvt
include "$TSMC_DIR/oa/models/spectre/crn65lp_2d5_lk_v1d7.scs" section=tt_dio_25
include "$TSMC_DIR/oa/models/spectre/crn65lp_2d5_lk_v1d7.scs" section=tt_rfmos_lvt
include "$TSMC_DIR/oa/models/spectre/crn65lp_2d5_lk_v1d7.scs" section=stat_noise

//include "$TSMC_DIR/oa/models/spectre/crn65lp_2d5_lk_v1d7.scs" section=tt_rfmos_25ud18
//include "$TSMC_DIR/oa/models/spectre/crn65lp_2d5_lk_v1d7.scs" section=tt_rfmos_25od33
//include "$TSMC_DIR/oa/models/spectre/crn65lp_2d5_lk_v1d7.scs" section=tt_rfsbd
//include "$TSMC_DIR/oa/models/spectre/crn65lp_2d5_lk_v1d7.scs" section=tt_25ud18
//include "$TSMC_DIR/oa/models/spectre/crn65lp_2d5_lk_v1d7.scs" section=tt_25od33
//include "$TSMC_DIR/oa/models/spectre/crn65lp_2d5_lk_v1d7.scs" section=tt_hv25_snw_spw
//include "$TSMC_DIR/oa/models/spectre/crn65lp_2d5_lk_v1d7.scs" section=tt_bip_s
//include "$TSMC_DIR/oa/models/spectre/crn65lp_2d5_lk_v1d7.scs" section=tt_bip_npn_s
////include "$TSMC_DIR/oa/models/spectre/crn65lp_2d5_lk_v1d7.scs" section=tt_dio_25ud18
//include "$TSMC_DIR/oa/models/spectre/crn65lp_2d5_lk_v1d7.scs" section=tt_dio_18
//include "$TSMC_DIR/oa/models/spectre/crn65lp_2d5_lk_v1d7.scs" section=tt_dio_25od33
//include "$TSMC_DIR/oa/models/spectre/crn65lp_2d5_lk_v1d7.scs" section=stat_res
include "$TSMC_DIR/oa/models/spectre/crn65lp_2d5_lk_v1d7.scs" section=stat_mis
//include "$TSMC_DIR/oa/models/spectre/crn65lp_2d5_lk_v1d7.scs" section=stat_mis_hvt
//include "$TSMC_DIR/oa/models/spectre/crn65lp_2d5_lk_v1d7.scs" section=stat_mis_mlvt
//include "$TSMC_DIR/oa/models/spectre/crn65lp_2d5_lk_v1d7.scs" section=stat_mis_lvt
include "$TSMC_DIR/oa/models/spectre/crn65lp_2d5_lk_v1d7.scs" section=stat_mis_18
//include "$TSMC_DIR/oa/models/spectre/crn65lp_2d5_lk_v1d7.scs" section=stat_mis_25
//include "$TSMC_DIR/oa/models/spectre/crn65lp_2d5_lk_v1d7.scs" section=stat_mis_33
//include "$TSMC_DIR/oa/models/spectre/crn65lp_2d5_lk_v1d7.scs" section=stat_mis_25ud18
//include "$TSMC_DIR/oa/models/spectre/crn65lp_2d5_lk_v1d7.scs" section=stat_mis_25od33
//include "$TSMC_DIR/oa/models/spectre/crn65lp_2d5_lk_v1d7.scs" section=stat_mis_na
//include "$TSMC_DIR/oa/models/spectre/crn65lp_2d5_lk_v1d7.scs" section=stat_mis_na25
//include "$TSMC_DIR/oa/models/spectre/crn65lp_2d5_lk_v1d7.scs" section=stat_mis_hv25_snw_spw
//include "$TSMC_DIR/oa/models/spectre/crn65lp_2d5_lk_v1d7.scs" section=stat_mis_bip
//include "$TSMC_DIR/oa/models/spectre/crn65lp_2d5_lk_v1d7.scs" section=stat_mis_bip_npn
//include "$TSMC_DIR/oa/models/spectre/crn65lp_2d5_lk_v1d7.scs" section=stat_mis_bip_s
//include "$TSMC_DIR/oa/models/spectre/crn65lp_2d5_lk_v1d7.scs" section=stat_mis_bip_npn_s
//include "$TSMC_DIR/oa/models/spectre/crn65lp_2d5_lk_v1d7.scs" section=stat_mis_mos_cap
//include "$TSMC_DIR/oa/models/spectre/crn65lp_2d5_lk_v1d7.scs" section=stat_mis_mos_cap_25
//include "$TSMC_DIR/oa/models/spectre/crn65lp_2d5_lk_v1d7.scs" section=stat_mis_res
//include "$TSMC_DIR/oa/models/spectre/crn65lp_2d5_lk_v1d7.scs" section=stat_mis_disres
//include "$TSMC_DIR/oa/models/spectre/crn65lp_2d5_lk_v1d7.scs" section=stat_mis_mim
//include "$TSMC_DIR/oa/models/spectre/crn65lp_2d5_lk_v1d7.scs" section=stat_mis_rtmom
//include "$TSMC_DIR/oa/models/spectre/crn65lp_2d5_lk_v1d7.scs" section=stat_mis_rfmos
//include "$TSMC_DIR/oa/models/spectre/crn65lp_2d5_lk_v1d7.scs" section=stat_mis_rfmos_hvt
//include "$TSMC_DIR/oa/models/spectre/crn65lp_2d5_lk_v1d7.scs" section=stat_mis_rfmos_mlvt
//include "$TSMC_DIR/oa/models/spectre/crn65lp_2d5_lk_v1d7.scs" section=stat_mis_rfmos_lvt
//include "$TSMC_DIR/oa/models/spectre/crn65lp_2d5_lk_v1d7.scs" section=stat_mis_rfmos_18
//include "$TSMC_DIR/oa/models/spectre/crn65lp_2d5_lk_v1d7.scs" section=stat_mis_rfmos_25ud18
//include "$TSMC_DIR/oa/models/spectre/crn65lp_2d5_lk_v1d7.scs" section=stat_mis_rfmos_25
//include "$TSMC_DIR/oa/models/spectre/crn65lp_2d5_lk_v1d7.scs" section=stat_mis_rfmos_25od33
//include "$TSMC_DIR/oa/models/spectre/crn65lp_2d5_lk_v1d7.scs" section=stat_mis_rfmos_33
//include "$TSMC_DIR/oa/models/spectre/crn65lp_2d5_lk_v1d7.scs" section=stat_mis_rfmim
//include "$TSMC_DIR/oa/models/spectre/crn65lp_2d5_lk_v1d7.scs" section=stat_mis_rfmvar
//include "$TSMC_DIR/oa/models/spectre/crn65lp_2d5_lk_v1d7.scs" section=stat_mis_rfmvar_hvt
//include "$TSMC_DIR/oa/models/spectre/crn65lp_2d5_lk_v1d7.scs" section=stat_mis_rfmvar_25
//include "$TSMC_DIR/oa/models/spectre/crn65lp_2d5_lk_v1d7.scs" section=stat_mis_rfres_sa
//include "$TSMC_DIR/oa/models/spectre/crn65lp_2d5_lk_v1d7.scs" section=stat_mis_rfres_rpo
//include "$TSMC_DIR/oa/models/spectre/crn65lp_2d5_lk_v1d7.scs" section=stat_mis_rfrtmom
//include "$TSMC_DIR/oa/models/spectre/crn65lp_2d5_lk_v1d7.scs" section=tt_probe
parOpt options redefinedparams=ignore
parameters mismatchflag_mos_rf=0
parameters mismatchflag_mos_rf_hvt=0
parameters mismatchflag_mos_rf_lvt=0
parameters mismatchflag_mos_rf_mlvt=0
parameters mismatchflag_mos_rf_25=0
parameters mismatchflag_mos_rf_18=0
parameters mismatchflag_mos_rf_33=0
parameters mismatchflag_caprf=0
parameters mismatchflag_caprfhvt=0
parameters mismatchflag_caprf25=0
parameters mismatchflag_rfres_sa=0
parameters mismatchflag_rfres_rpo=0
parameters mismatchflag_rfrtmom=0
parameters mismatchflag_rfmim=0
parameters mismatchflag_mos_rf_25ud18=0
parameters mismatchflag_mos_rf_25od33=0
parameters mismatchflag_mos=0
parameters mismatchflag_mos_hvt=0
parameters mismatchflag_mos_mlvt=0
parameters mismatchflag_mos_lvt=0
parameters mismatchflag_mos_18=0
parameters mismatchflag_mos_25=0
parameters mismatchflag_mos_33=0
parameters mismatchflag_mos_25ud18=0
parameters mismatchflag_mos_25od33=0
parameters mismatchflag_mos_na=0
parameters mismatchflag_mos_na25=0
parameters mismatchflag_mos_hv25_snw_spw=0
parameters mismatchflag_bip=0
parameters mismatchflag_bip_npn=0
parameters mismatchflag_bip_s=0
parameters mismatchflag_bip_npn_s=0
parameters mismatchflag_cap=0
parameters mismatchflag_cap_25=0
parameters mismatchflag_res=0
parameters mismatchflag_disres=0
parameters mismatchflag_mim=0
parameters mismatchflag_rtmom=0
