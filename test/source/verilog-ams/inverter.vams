`include "disciplines.vams"

module inverter(in,out);
	input in;
	output out;
	electrical in,out;

	parameter real supply_voltage = 1.2;

	real high;

	analog begin
		high = V(in);
		V(out) <+ transition(high<supply_voltage/2.0?supply_voltage:0,0,100p,100p);
	end
endmodule
